# Ansys Electronics Desktop project, version 2017.0
materials:
  steel_1010: permittivity=1 permeability{BType=normal HUnit=A_per_meter BUnit=tesla curve (0, 0) (238.7, 0.2003) (318.3, 0.3204) (358.1, 0.40045) (437.7, 0.50055) (477.5, 0.5606) (636.6, 0.7908) (795.8, 0.931) (1114.1, 1.1014) (1273.2, 1.2016) (1591.5, 1.302) (2228.2, 1.4028) (3183.1, 1.524) (4774.6, 1.626) (6366.2, 1.698) (7957.7, 1.73) (15915.5, 1.87) (31831, 1.99) (47746.5, 2.04) (63662, 2.07) (79577.5, 2.095) (159155, 2.2) (318310, 2.4)} conductivity=2000000 lande_g_factor=2 mass_density=7872
  aluminum: permeability=1.000021 conductivity=38000000 mass_density=2689
  vacuum: permittivity=1
  steel_1010_2DSF0.950: permeability{BType=normal HUnit=A_per_meter BUnit=tesla curve (0, 0) (238.7, 0.1903) (318.3, 0.3044) (358.1, 0.38045) (437.7, 0.47555) (477.5, 0.5326) (636.6, 0.7513) (795.8, 0.8845) (1114.1, 1.0464) (1273.2, 1.1416) (1591.5, 1.237) (2228.2, 1.3328) (3183.1, 1.448) (4774.6, 1.545) (6366.2, 1.6135) (7957.7, 1.644) (15915.5, 1.7775) (31831, 1.8925) (47746.5, 1.941) (63662, 1.9705) (79577.5, 1.99525) (159155, 2.1) (318310, 2.3) (1909860, 4.3)} conductivity=2000000 mass_density=7478.4
  aluminum_75C: conductivity=38000000
  copper: permeability=0.999991 conductivity=58000000 mass_density=8933
  steel_1010_3DSF0.950: permeability{BType=normal HUnit=A_per_meter BUnit=tesla curve (0, 0) (238.7, 0.2003) (318.3, 0.3204) (358.1, 0.40045) (437.7, 0.50055) (477.5, 0.5606) (636.6, 0.7908) (795.8, 0.931) (1114.1, 1.1014) (1273.2, 1.2016) (1591.5, 1.302) (2228.2, 1.4028) (3183.1, 1.524) (4774.6, 1.626) (6366.2, 1.698) (7957.7, 1.73) (15915.5, 1.87) (31831, 1.99) (47746.5, 2.04) (63662, 2.07) (79577.5, 2.095) (159155, 2.2) (318310, 2.4) (1909860, 4.4)} conductivity=2000000 mass_density=7872 stacking_type=Lamination stacking_factor=0.95 stacking_direction=V(3)
  steel_1011: permittivity=1 permeability{BType=normal HUnit=A_per_meter BUnit=tesla curve (0, 0) (238.7, 0.2003) (318.3, 0.3204) (358.1, 0.40045) (437.7, 0.50055) (477.5, 0.5606) (636.6, 0.7908) (795.8, 0.931) (1114.1, 1.1014) (1273.2, 1.2016) (1591.5, 1.302) (2228.2, 1.4028) (3183.1, 1.524) (4774.6, 1.626) (6366.2, 1.698) (7957.7, 1.73) (15915.5, 1.87) (31831, 1.99) (47746.5, 2.04) (63662, 2.07) (79577.5, 2.095) (159155, 2.2) (318310, 2.4)} conductivity=2000000 lande_g_factor=2 core_loss_type="Electrical Steel" core_loss_kh=143 core_loss_ke=0.53 mass_density=7872
  FLNGT33J: permeability{BType=normal HUnit=A_per_meter BUnit=tesla curve (-136000, 0) (-133868, 0.0355836) (-131482, 0.0711672) (-128792, 0.106751) (-125738, 0.142334) (-122239, 0.177918) (-118191, 0.213502) (-113454, 0.249085) (-107834, 0.284669) (-101061, 0.320252) (-92739.4, 0.355836) (-82435, 0.391024) (-72130.6, 0.423396) (-61826.2, 0.455768) (-51521.9, 0.488141) (-41217.5, 0.520513) (-30913.1, 0.552885) (-20608.7, 0.585257) (-10304.4, 0.617629) (0, 0.65)} magnetic_coercivity{Magnitude=-136000A_per_meter DirComp1=1 DirComp2=0 DirComp3=0}
  JFE_Steel_20JNEH1500: core_loss_curve{50Hz (0, 0) (0.5, 0.33) (0.55, 0.38) (0.6, 0.44) (0.65, 0.51) (0.7, 0.57) (0.75, 0.64) (0.8, 0.71) (0.85, 0.79) (0.9, 0.87) (0.95, 0.95) (1, 1.03) (1.05, 1.13) (1.1, 1.23) (1.15, 1.34) (1.2, 1.48) (1.25, 1.62) (1.3, 1.78) (1.35, 1.95) (1.4, 2.13) (1.45, 2.32) (1.5, 2.51) (1.55, 2.71) (1.6, 2.92) (1.65, 3.14) (1.7, 3.37)} core_loss_curve{60Hz (0, 0) (0.5, 0.4) (0.55, 0.47) (0.6, 0.55) (0.65, 0.63) (0.7, 0.71) (0.75, 0.79) (0.8, 0.88) (0.85, 0.96) (0.9, 1.06) (0.95, 1.16) (1, 1.27) (1.05, 1.39) (1.1, 1.52) (1.15, 1.67) (1.2, 1.84) (1.25, 2.02) (1.3, 2.2) (1.35, 2.4) (1.4, 2.61) (1.45, 2.84) (1.5, 3.07) (1.55, 3.32) (1.6, 3.58) (1.65, 3.84) (1.7, 4.1)} core_loss_curve{100Hz (0, 0) (0.062, 0.01) (0.1, 0.0302) (0.2, 0.138) (0.3, 0.295) (0.4, 0.484) (0.5, 0.699) (0.6, 0.944) (0.7, 1.21) (0.8, 1.51) (0.9, 1.83) (1, 2.18) (1.1, 2.57) (1.2, 3.01) (1.3, 3.49) (1.4, 4.04) (1.5, 4.7)} core_loss_curve{200Hz (0, 0) (0.046, 0.01) (0.1, 0.0695) (0.2, 0.31) (0.3, 0.672) (0.4, 1.1) (0.5, 1.6) (0.6, 2.15) (0.7, 2.76) (0.8, 3.42) (0.9, 4.14) (1, 4.95) (1.1, 5.84) (1.2, 6.81) (1.3, 7.93) (1.4, 9.28) (1.5, 10.7)} core_loss_curve{400Hz (0, 0) (0.0295, 0.01) (0.1, 0.174) (0.2, 0.73) (0.3, 1.57) (0.4, 2.63) (0.5, 3.88) (0.6, 5.3) (0.7, 6.81) (0.8, 8.49) (0.9, 10.4) (1, 12.5) (1.1, 14.9) (1.2, 17.5) (1.3, 20.3) (1.4, 23.5) (1.5, 27.2)} core_loss_curve{1kHz (0, 0) (0.015, 0.01) (0.1, 0.632) (0.2, 2.64) (0.3, 5.62) (0.4, 9.48) (0.5, 14.1) (0.6, 19.4) (0.7, 25.2) (0.8, 31.6) (0.9, 39) (1, 47.3) (1.1, 56.6) (1.2, 66.7) (1.3, 78) (1.4, 90.9) (1.45, 100)} core_loss_curve{2kHz (0, 0) (0.01, 0.0145) (0.1, 1.82) (0.2, 7.04) (0.3, 15.3) (0.4, 25.9) (0.5, 37.9) (0.6, 52.5) (0.7, 69.1) (0.8, 88.6) (0.85, 100)} core_loss_curve{5kHz (0, 0) (0.01, 0.086) (0.05, 2.09) (0.1, 8.18) (0.15, 17.9) (0.2, 30.5) (0.3, 63.9) (0.39, 100)} core_loss_curve{10kHz (0, 0) (0.01, 0.29) (0.05, 6.6) (0.1, 25.3) (0.15, 54) (0.2, 90.6) (0.21, 100)} permeability{BType=normal HUnit=A_per_meter BUnit=tesla curve (0, 0) (10, 0.02) (20.8, 0.05) (28.7, 0.1) (34.6, 0.15) (39.2, 0.2) (43.1, 0.2501) (46.4, 0.3001) (49.2, 0.3501) (51.7, 0.4001) (54.1, 0.4501) (56.7, 0.5001) (59.4, 0.5501) (62.5, 0.6001) (65.7, 0.6501) (69.1, 0.7001) (73.1, 0.7501) (77.4, 0.8001) (82.6, 0.8501) (88.4, 0.9001) (95.3, 0.9501) (104, 1.0001) (113, 1.0501) (125, 1.1002) (140, 1.1502) (158, 1.2002) (183, 1.2502) (216, 1.3003) (262, 1.3503) (336, 1.4004) (493, 1.4506) (950, 1.5012) (1740, 1.5522) (2780, 1.6035) (4070, 1.6551) (5000, 1.6845) (5720, 1.7072) (7840, 1.7599) (10000, 1.8003) (10700, 1.8133) (14500, 1.8682) (20000, 1.9251) (30400, 1.9882) (80000, 2.0905)} conductivity=2127660 core_loss_type="Electrical Steel" core_loss_kh=176.31636 core_loss_kc=0.10233728 core_loss_ke=2.7238274 mass_density=7650
  steel_1008: permeability{BType=normal HUnit=A_per_meter BUnit=tesla curve (0, 0) (159.2, 0.2402) (318.3, 0.8654) (477.5, 1.1106) (636.6, 1.2458) (795.8, 1.331) (1591.5, 1.5) (3183.1, 1.6) (4774.6, 1.683) (6366.2, 1.741) (7957.7, 1.78) (15915.5, 1.905) (31831, 2.025) (47746.5, 2.085) (63662, 2.13) (79577.5, 2.165) (159155, 2.28) (318310, 2.485) (397887, 2.5851)} conductivity=2000000 mass_density=7872

design RMxprtDesign1 (RMxprt, Three Phase Induction Motor, model units mm)
machine:
  Machine: FrictionLoss=0W WindLoss=0W ReferenceSpeed=1277rpm NumberOfPoles=4 StrayLossFactor=0.01
  Stator: SkewWidth=0 NumberOfSlots=36 LaminationSectors=0 PressBoardThickness=0mm OuterDiameter=170mm InnerDiameter=115mm Length=150mm StackingFactor=0.95 SteelType=steel_1010 SlotType=4
  Rotor: OuterDiameter=114.6mm InnerDiameter=45mm Length=150mm SteelType=steel_1010 NumberOfSlots=33 SlotType=4 SkewWidth=1 BottomSlotType=UserDefinedSlot StackingFactor=0.95
  Shaft:
  Stator Slot: Hs0=0.62mm Hs1=0mm Hs2=16.2mm Bs0=2.5mm Bs1=5mm Bs2=7.26mm Rs=2.56mm ToothWidth=0mm
  Stator Winding: WindingType=Half-Coiled WindingLayers=1 ParallelBranches=1 ConductorsPerSlot=45 CoilPitch=0 EndAdjustment=0mm BaseInnerRadius=0mm TipInnerDiameter=0mm EndClearance=0mm CoilWrap=0mm SlotLiner=0mm WedgeThickness=0mm LayerInsulation=0mm BottomInsulation=0mm LimitedFillFactor=0.75 WdgNumberofPriodicMultipler=1 NumberOfStrands=1 WireWrap=0.01mm InterturnInsulation=0mm WireDiameter=1.45mm WireWidth=0mm WireThickness=0mm Gauge=15
  Rotor Slot: Hs0=0.7mm Hs1=0mm Hs2=16mm Bs0=1.1mm Bs1=4.31mm Bs2=2.1mm Rs=0.994mm Hs01=0mm
  Rotor Winding: BarConductorType=aluminum EndLength=0mm EndRingWidth=50mm EndRingHeight=20mm EndRingConductorType=aluminum
setups:
  Setup1: TPIM Motor RatedOutputPower=3025W RatedVoltage=380V RatedSpeed=1355rpm OperatingTemperature=75cel LoadType=ConstPower Frequency=50Hz WindingConnection=0

design Maxwell2DDesign1 (Maxwell 2D, Transient, XY geometry, model units mm)
options: ModelDepth=150mm Multiplier=fractions
variables:
  fractions = 1
geometry:
  Shaft [vacuum] = user_primitive(RMxprt/Band, DiaGap=114.8mm, DiaYoke=45mm, Length=0mm, SegAngle=0.83333333deg, Fractions=1, HalfAxial=0, InfoCore=100)
  OuterRegion [vacuum] = user_primitive(RMxprt/Band, DiaGap=114.8mm, DiaYoke=170mm, Length=0mm, SegAngle=0.83333333deg, Fractions=fractions, HalfAxial=0, InfoCore=100)
  Tool = user_primitive(RMxprt/Band, DiaGap=114.8mm, DiaYoke=170mm, Length=0mm, SegAngle=0.83333333deg, Fractions=fractions, HalfAxial=0, InfoCore=1)
  Stator [steel_1010_2DSF0.950] = user_primitive(RMxprt/SlotCore, DiaGap=115mm, DiaYoke=170mm, Length=0mm, Skew=0deg, Slots=36, SlotType=4, Hs0=0.62mm, Hs01=0mm, Hs1=0mm, Hs2=16.2mm, Bs0=2.5mm, Bs1=5mm, Bs2=7.26mm, Rs=2.56mm, FilletType=0, HalfSlot=0, SegAngle=15deg, LenRegion=0mm, InfoCore=0)
  Coil_0 [copper] = user_primitive(RMxprt/LapCoil, DiaGap=115mm, DiaYoke=170mm, Length=0mm, Skew=0deg, Slots=36, SlotType=4, Hs0=0.62mm, Hs1=0mm, Hs2=16.2mm, Bs0=2.5mm, Bs1=5mm, Bs2=7.26mm, Rs=2.56mm, FilletType=0, Layers=1, CoilPitch=2, EndExt=0mm, SpanExt=0mm, BendAngle=0deg, SegAngle=10deg, LenRegion=0mm, InfoCoil=2)
  Coil_1..Coil_35 [copper] = Coil_0.duplicate_around_axis(axis=Z, angle=10deg, total=36)
  Rotor [steel_1010_2DSF0.950] = user_primitive(RMxprt/SlotCore, DiaGap=114.6mm, DiaYoke=45mm, Length=0mm, Skew=0deg, Slots=33, SlotType=4, Hs0=0.7mm, Hs01=0mm, Hs1=0mm, Hs2=16mm, Bs0=1.1mm, Bs1=4.31mm, Bs2=2.1mm, Rs=0.994mm, FilletType=0, HalfSlot=0, SegAngle=15deg, LenRegion=0mm, InfoCore=0)
  Bar [aluminum_75C] = user_primitive(RMxprt/SquirrelCage, DiaGap=114.6mm, DiaYoke=45mm, Length=0mm, Skew=0deg, Slots=33, SlotType=4, Hs0=0.7mm, Hs01=0mm, Hs1=0mm, Hs2=16mm, Bs0=1.1mm, Bs1=4.31mm, Bs2=2.1mm, Rs=0.994mm, FilletType=0, HalfSlot=0, BarEndExt=0mm, RingLength=50mm, RingHeight=20mm, RingDiaGap=0mm, CastRotor=0, SegAngle=15deg, LenRegion=0mm, InfoCoil=0)
  Tool_1 = Tool.copy()
  Bar.subtract(Tool_1)
  Bar_Separate1..Bar_Separate32 [aluminum_75C] = Bar.separate_bodies()
  InnerRegion [vacuum] = user_primitive(RMxprt/SlotCore, DiaGap=114.6mm, DiaYoke=45mm, Length=0mm, Skew=0deg, Slots=33, SlotType=4, Hs0=0.7mm, Hs01=0mm, Hs1=0mm, Hs2=16mm, Bs0=1.1mm, Bs1=4.31mm, Bs2=2.1mm, Rs=0.994mm, FilletType=0, HalfSlot=0, SegAngle=15deg, LenRegion=0mm, InfoCore=100)
  Tool_3 = Tool.copy()
  InnerRegion.subtract(Tool_3)
  Tool_4 = Tool.copy()
  Shaft.subtract(Tool_4)
  Tool_5 = Tool.copy()
  Stator.subtract(Tool_5)
  Tool_6 = Tool.copy()
  Coil_0.subtract(Tool_6)
  Tool_7 = Tool.copy()
  Coil_1.subtract(Tool_7)
  Tool_8 = Tool.copy()
  Coil_2.subtract(Tool_8)
  Tool_9 = Tool.copy()
  Coil_3.subtract(Tool_9)
  Tool_10 = Tool.copy()
  Coil_4.subtract(Tool_10)
  Tool_11 = Tool.copy()
  Coil_5.subtract(Tool_11)
  Tool_12 = Tool.copy()
  Coil_6.subtract(Tool_12)
  Tool_13 = Tool.copy()
  Coil_7.subtract(Tool_13)
  Tool_14 = Tool.copy()
  Coil_8.subtract(Tool_14)
  Tool_15 = Tool.copy()
  Coil_9.subtract(Tool_15)
  Tool_16 = Tool.copy()
  Coil_10.subtract(Tool_16)
  Tool_17 = Tool.copy()
  Coil_11.subtract(Tool_17)
  Tool_18 = Tool.copy()
  Coil_12.subtract(Tool_18)
  Tool_19 = Tool.copy()
  Coil_13.subtract(Tool_19)
  Tool_20 = Tool.copy()
  Coil_14.subtract(Tool_20)
  Tool_21 = Tool.copy()
  Coil_15.subtract(Tool_21)
  Tool_22 = Tool.copy()
  Coil_16.subtract(Tool_22)
  Tool_23 = Tool.copy()
  Coil_17.subtract(Tool_23)
  Tool_24 = Tool.copy()
  Coil_18.subtract(Tool_24)
  Tool_25 = Tool.copy()
  Coil_19.subtract(Tool_25)
  Tool_26 = Tool.copy()
  Coil_20.subtract(Tool_26)
  Tool_27 = Tool.copy()
  Coil_21.subtract(Tool_27)
  Tool_28 = Tool.copy()
  Coil_22.subtract(Tool_28)
  Tool_29 = Tool.copy()
  Coil_23.subtract(Tool_29)
  Tool_30 = Tool.copy()
  Coil_24.subtract(Tool_30)
  Tool_31 = Tool.copy()
  Coil_25.subtract(Tool_31)
  Tool_32 = Tool.copy()
  Coil_26.subtract(Tool_32)
  Tool_33 = Tool.copy()
  Coil_27.subtract(Tool_33)
  Tool_34 = Tool.copy()
  Coil_28.subtract(Tool_34)
  Tool_35 = Tool.copy()
  Coil_29.subtract(Tool_35)
  Tool_36 = Tool.copy()
  Coil_30.subtract(Tool_36)
  Tool_37 = Tool.copy()
  Coil_31.subtract(Tool_37)
  Tool_38 = Tool.copy()
  Coil_32.subtract(Tool_38)
  Tool_39 = Tool.copy()
  Coil_33.subtract(Tool_39)
  Tool_40 = Tool.copy()
  Coil_34.subtract(Tool_40)
  Tool_41 = Tool.copy()
  Coil_35.subtract(Tool_41)
  Rotor.subtract(Tool)
boundaries and excitations:
  VectorPotential1: Vector Potential Edges=OuterRegion.edge(at (0, 85, 0)) Value=0
  PhA_0: Coil Objects=Coil_0 Conductor_number=45 Winding=PhaseA PolarityType=Positive
  PhARe_0: Coil Objects=Coil_9 Conductor_number=45 Winding=PhaseA PolarityType=Negative
  PhA_1: Coil Objects=Coil_1 Conductor_number=45 Winding=PhaseA PolarityType=Positive
  PhARe_1: Coil Objects=Coil_10 Conductor_number=45 Winding=PhaseA PolarityType=Negative
  PhA_2: Coil Objects=Coil_2 Conductor_number=45 Winding=PhaseA PolarityType=Positive
  PhARe_2: Coil Objects=Coil_11 Conductor_number=45 Winding=PhaseA PolarityType=Negative
  PhB_3: Coil Objects=Coil_6 Conductor_number=45 Winding=PhaseB PolarityType=Positive
  PhBRe_3: Coil Objects=Coil_15 Conductor_number=45 Winding=PhaseB PolarityType=Negative
  PhB_4: Coil Objects=Coil_7 Conductor_number=45 Winding=PhaseB PolarityType=Positive
  PhBRe_4: Coil Objects=Coil_16 Conductor_number=45 Winding=PhaseB PolarityType=Negative
  PhB_5: Coil Objects=Coil_8 Conductor_number=45 Winding=PhaseB PolarityType=Positive
  PhBRe_5: Coil Objects=Coil_17 Conductor_number=45 Winding=PhaseB PolarityType=Negative
  PhC_6: Coil Objects=Coil_12 Conductor_number=45 Winding=PhaseC PolarityType=Positive
  PhCRe_6: Coil Objects=Coil_21 Conductor_number=45 Winding=PhaseC PolarityType=Negative
  PhC_7: Coil Objects=Coil_13 Conductor_number=45 Winding=PhaseC PolarityType=Positive
  PhCRe_7: Coil Objects=Coil_22 Conductor_number=45 Winding=PhaseC PolarityType=Negative
  PhC_8: Coil Objects=Coil_14 Conductor_number=45 Winding=PhaseC PolarityType=Positive
  PhCRe_8: Coil Objects=Coil_23 Conductor_number=45 Winding=PhaseC PolarityType=Negative
  PhA_9: Coil Objects=Coil_18 Conductor_number=45 Winding=PhaseA PolarityType=Positive
  PhARe_9: Coil Objects=Coil_27 Conductor_number=45 Winding=PhaseA PolarityType=Negative
  PhA_10: Coil Objects=Coil_19 Conductor_number=45 Winding=PhaseA PolarityType=Positive
  PhARe_10: Coil Objects=Coil_28 Conductor_number=45 Winding=PhaseA PolarityType=Negative
  PhA_11: Coil Objects=Coil_20 Conductor_number=45 Winding=PhaseA PolarityType=Positive
  PhARe_11: Coil Objects=Coil_29 Conductor_number=45 Winding=PhaseA PolarityType=Negative
  PhB_12: Coil Objects=Coil_24 Conductor_number=45 Winding=PhaseB PolarityType=Positive
  PhBRe_12: Coil Objects=Coil_33 Conductor_number=45 Winding=PhaseB PolarityType=Negative
  PhB_13: Coil Objects=Coil_25 Conductor_number=45 Winding=PhaseB PolarityType=Positive
  PhBRe_13: Coil Objects=Coil_34 Conductor_number=45 Winding=PhaseB PolarityType=Negative
  PhB_14: Coil Objects=Coil_26 Conductor_number=45 Winding=PhaseB PolarityType=Positive
  PhBRe_14: Coil Objects=Coil_35 Conductor_number=45 Winding=PhaseB PolarityType=Negative
  PhC_15: Coil Objects=Coil_30 Conductor_number=45 Winding=PhaseC PolarityType=Positive
  PhCRe_15: Coil Objects=Coil_3 Conductor_number=45 Winding=PhaseC PolarityType=Negative
  PhC_16: Coil Objects=Coil_31 Conductor_number=45 Winding=PhaseC PolarityType=Positive
  PhCRe_16: Coil Objects=Coil_4 Conductor_number=45 Winding=PhaseC PolarityType=Negative
  PhC_17: Coil Objects=Coil_32 Conductor_number=45 Winding=PhaseC PolarityType=Positive
  PhCRe_17: Coil Objects=Coil_5 Conductor_number=45 Winding=PhaseC PolarityType=Negative
  EndConnection1: End Connection Objects=[Bar, Bar_Separate1..Bar_Separate32] ResistanceValue=2.3349e-007ohm InductanceValue=1.32878e-008H
  PhaseA: Winding Group Type=Voltage IsSolid=false Current=0A Resistance=2.03064ohm Inductance=0.00402611H Voltage="310.269 * sin(2*pi*50*time)" ParallelBranchesNum=1
  PhaseB: Winding Group Type=Voltage IsSolid=false Current=0A Resistance=2.03064ohm Inductance=0.00402611H Voltage="310.269 * sin(2*pi*50*time-2*pi/3)" ParallelBranchesNum=1
  PhaseC: Winding Group Type=Voltage IsSolid=false Current=0A Resistance=2.03064ohm Inductance=0.00402611H Voltage="310.269 * sin(2*pi*50*time-4*pi/3)" ParallelBranchesNum=1
  Y connection: PhaseA, PhaseB, PhaseC
mesh:
  Length_Coil: LengthBased RefineInside Objects=[Coil_0..Coil_35] MaxLength=3.065mm
  Length_Bar: LengthBased RefineInside Objects=[Bar, Bar_Separate1..Bar_Separate32] MaxLength=1.05mm
  SurfApprox_Bar: SurfApproxBased Objects=[Bar, Bar_Separate1..Bar_Separate32] CurvedSurfaceApproxChoice=ManualSettings SurfDev=0.0573mm NormalDev=15deg
  SurfApprox_Main: SurfApproxBased Objects=[Stator, Rotor, OuterRegion, InnerRegion, Shaft] CurvedSurfaceApproxChoice=ManualSettings SurfDev=0.085mm NormalDev=15deg
  Length_Main: LengthBased RefineInside Objects=[Stator, Rotor, OuterRegion, InnerRegion, Shaft] MaxLength=5.54mm
  initial mesh: MeshMethod=AnsoftTAU
setups:
  Setup1: Transient NonlinearSolverResidual=0.0001 StopTime=20ms TimeStep=2ms FastReachSteadyState FrequencyOfAddedVoltageSource=50Hz SweepSetupType=LinearStep StartValue=0ns StopValue=20ms StepSize=2ms InitialTimeStep=0.002s MinTimeStep=0.001s MaxTimeStep=0.003s TimeStepErrTolerance=0.0001
field plots:
  Mag_B1: B over Shaft, OuterRegion, Stator, Coil_0..Coil_35, Rotor, Bar, Bar_Separate1..Bar_Separate32, InnerRegion on Setup1 : Transient at Time=0.02s
reports:
  Torque: Moving1.Torque vs Time on Setup1 : Transient
  Currents: Current(PhaseA), Current(PhaseB), Current(PhaseC) vs Time on Setup1 : Transient
  Induced Voltages: InducedVoltage(PhaseA), InducedVoltage(PhaseB), InducedVoltage(PhaseC) vs Time on Setup1 : Transient
  Flux Linkages: FluxLinkage(PhaseA), FluxLinkage(PhaseB), FluxLinkage(PhaseC) vs Time on Setup1 : Transient
  Voltages: InputVoltage(PhaseA), InputVoltage(PhaseB), InputVoltage(PhaseC) vs Time on Setup1 : Transient
  Powers: InputVoltage(PhaseA)*Current(PhaseA) + InputVoltage(PhaseB)*Current(PhaseB) + InputVoltage(PhaseC)*Current(PhaseC), Moving1.Speed*Moving1.Torque vs Time on Setup1 : Transient
