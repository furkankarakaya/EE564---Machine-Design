# Ansys Electronics Desktop project, version 2017.0
materials:
  steel_1010: permittivity=1 permeability{BType=normal HUnit=A_per_meter BUnit=tesla curve (0, 0) (238.7, 0.2003) (318.3, 0.3204) (358.1, 0.40045) (437.7, 0.50055) (477.5, 0.5606) (636.6, 0.7908) (795.8, 0.931) (1114.1, 1.1014) (1273.2, 1.2016) (1591.5, 1.302) (2228.2, 1.4028) (3183.1, 1.524) (4774.6, 1.626) (6366.2, 1.698) (7957.7, 1.73) (15915.5, 1.87) (31831, 1.99) (47746.5, 2.04) (63662, 2.07) (79577.5, 2.095) (159155, 2.2) (318310, 2.4)} conductivity=2000000 lande_g_factor=2 mass_density=7872
  aluminum: permeability=1.000021 conductivity=38000000 mass_density=2689

design RMxprtDesign1 (RMxprt, Three Phase Induction Motor, model units mm)
machine:
  Machine: FrictionLoss=0W WindLoss=0W ReferenceSpeed=1277rpm NumberOfPoles=4 StrayLossFactor=0.01
  Stator: SkewWidth=0 NumberOfSlots=36 LaminationSectors=0 PressBoardThickness=0mm OuterDiameter=170mm InnerDiameter=115mm Length=150mm StackingFactor=0.95 SteelType=steel_1010 SlotType=4
  Rotor: OuterDiameter=114.56mm InnerDiameter=45mm Length=150mm SteelType=steel_1010 NumberOfSlots=33 SlotType=4 SkewWidth=1 BottomSlotType=UserDefinedSlot StackingFactor=0.95
  Shaft:
  Stator Slot: Hs0=0.62mm Hs1=0mm Hs2=16.2mm Bs0=2.5mm Bs1=5mm Bs2=7.26mm Rs=2.56mm ToothWidth=0mm
  Stator Winding: WindingType=Half-Coiled WindingLayers=1 ParallelBranches=1 ConductorsPerSlot=50 CoilPitch=0 EndAdjustment=0mm BaseInnerRadius=0mm TipInnerDiameter=0mm EndClearance=0mm CoilWrap=0mm SlotLiner=0mm WedgeThickness=0mm LayerInsulation=0mm BottomInsulation=0mm LimitedFillFactor=0.75 WdgNumberofPriodicMultipler=1 NumberOfStrands=1 WireWrap=0.01mm InterturnInsulation=0mm WireDiameter=1.369mm WireWidth=0mm WireThickness=0mm Gauge=15
  Rotor Slot: Hs0=0.7mm Hs1=0mm Hs2=16mm Bs0=1.1mm Bs1=4.31mm Bs2=2.1mm Rs=0.994mm Hs01=0mm
  Rotor Winding: BarConductorType=aluminum EndLength=0.1mm EndRingWidth=50mm EndRingHeight=20mm EndRingConductorType=aluminum
setups:
  Setup1: TPIM Motor RatedOutputPower=2567W RatedVoltage=380V RatedSpeed=1277rpm OperatingTemperature=75cel LoadType=ConstPower Frequency=50Hz WindingConnection=0
