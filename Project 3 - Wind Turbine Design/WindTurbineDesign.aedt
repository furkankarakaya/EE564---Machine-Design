# Ansys Electronics Desktop project, version 2017.0
materials:
  steel_1008: permeability{BType=normal HUnit=A_per_meter BUnit=tesla curve (0, 0) (159.2, 0.2402) (318.3, 0.8654) (477.5, 1.1106) (636.6, 1.2458) (795.8, 1.331) (1591.5, 1.5) (3183.1, 1.6) (4774.6, 1.683) (6366.2, 1.741) (7957.7, 1.78) (15915.5, 1.905) (31831, 2.025) (47746.5, 2.085) (63662, 2.13) (79577.5, 2.165) (159155, 2.28) (318310, 2.485) (397887, 2.5851)} conductivity=2000000 mass_density=7872
  steel_1010: permittivity=1 permeability{BType=normal HUnit=A_per_meter BUnit=tesla curve (0, 0) (238.7, 0.2003) (318.3, 0.3204) (358.1, 0.40045) (437.7, 0.50055) (477.5, 0.5606) (636.6, 0.7908) (795.8, 0.931) (1114.1, 1.1014) (1273.2, 1.2016) (1591.5, 1.302) (2228.2, 1.4028) (3183.1, 1.524) (4774.6, 1.626) (6366.2, 1.698) (7957.7, 1.73) (15915.5, 1.87) (31831, 1.99) (47746.5, 2.04) (63662, 2.07) (79577.5, 2.095) (159155, 2.2) (318310, 2.4)} conductivity=2000000 lande_g_factor=2 mass_density=7872
  aluminum: permeability=1.000021 conductivity=38000000 mass_density=2689
  copper: permeability=0.999991 conductivity=58000000 mass_density=8933
  vacuum: permittivity=1
  steel_1010_2DSF0.960: permeability{BType=normal HUnit=A_per_meter BUnit=tesla curve (0, 0) (238.7, 0.1923) (318.3, 0.3076) (358.1, 0.38445) (437.7, 0.48055) (477.5, 0.5382) (636.6, 0.7592) (795.8, 0.8938) (1114.1, 1.0574) (1273.2, 1.1536) (1591.5, 1.25) (2228.2, 1.3468) (3183.1, 1.4632) (4774.6, 1.5612) (6366.2, 1.6304) (7957.7, 1.6612) (15915.5, 1.796) (31831, 1.912) (47746.5, 1.9608) (63662, 1.9904) (79577.5, 2.0152) (159155, 2.12) (318310, 2.32) (1909860, 4.32)} conductivity=2000000 mass_density=7557.12
  aluminum_25C: conductivity=45307700
  DW540_50: permeability{BType=normal HUnit=A_per_meter BUnit=tesla curve (0, 0) (66, 0.4) (70, 0.45) (74, 0.5) (78, 0.55) (82, 0.6) (88, 0.65) (92, 0.7) (97, 0.75) (104, 0.8) (111, 0.85) (118, 0.9) (126, 0.95) (136, 1) (148, 1.05) (161, 1.1) (179, 1.15) (203, 1.2) (239, 1.25) (287, 1.3) (350, 1.35) (462, 1.4) (637, 1.45) (955, 1.5) (1513, 1.55) (2548, 1.6) (3822, 1.65) (5255, 1.7) (6847, 1.75) (10035, 1.8) (14006, 1.85) (19085, 1.9) (25048, 1.95) (32047, 2) (42605, 2.05) (56529, 2.1) (78025, 2.15) (103500, 2.2) (127390, 2.25) (156050, 2.3) (191080, 2.35)} core_loss_type="Electrical Steel" core_loss_kh=268 core_loss_kc=0.822 mass_density=7750
  D21_50: permeability{BType=normal HUnit=A_per_meter BUnit=tesla curve (0, 0) (140, 0.4) (155, 0.45) (171, 0.5) (191, 0.55) (212, 0.6) (237, 0.65) (267, 0.7) (302, 0.75) (340, 0.8) (380, 0.85) (425, 0.9) (476, 0.95) (536, 1) (602, 1.05) (675, 1.1) (765, 1.15) (880, 1.2) (1020, 1.25) (1200, 1.3) (1450, 1.35) (1740, 1.4) (2160, 1.45) (2800, 1.5) (3850, 1.55) (5290, 1.6) (6920, 1.65) (8800, 1.7) (11000, 1.75) (13800, 1.8) (17300, 1.85) (21400, 1.9) (25000, 1.95) (30000, 2)} core_loss_type="Electrical Steel" core_loss_kh=366 core_loss_kc=0.822 core_loss_ke=0.91 mass_density=7820
  JFE_Steel_SuperCore_20JNHF1300: core_loss_curve{50Hz (0, 0) (0.05, 0.004) (0.08, 0.012) (0.1, 0.019) (0.2, 0.066) (0.299, 0.133) (0.399, 0.217) (0.499, 0.315) (0.599, 0.428) (0.699, 0.551)} core_loss_curve{60Hz (0, 0) (0.05, 0.006) (0.08, 0.014) (0.1, 0.022) (0.2, 0.08) (0.3, 0.162) (0.4, 0.264) (0.5, 0.384) (0.6, 0.525) (0.7, 0.67)} core_loss_curve{100Hz (0, 0) (0.1, 0.038) (0.2, 0.14) (0.3, 0.283) (0.4, 0.463) (0.5, 0.673) (0.6, 0.919) (0.7, 1.187) (0.8, 1.435) (0.9, 1.683) (1, 1.953)} core_loss_curve{200Hz (0, 0) (0.1, 0.081) (0.2, 0.302) (0.3, 0.617) (0.4, 1.018) (0.5, 1.489) (0.6, 2.054) (0.7, 2.651) (0.8, 3.231) (0.9, 3.861) (1, 4.548) (1.1, 5.319)} core_loss_curve{400Hz (0, 0) (0.1, 0.182) (0.2, 0.684) (0.3, 1.414) (0.4, 2.322) (0.5, 3.432) (0.6, 4.73) (0.7, 6.169) (0.8, 7.637) (0.9, 9.281) (1, 11.144)} core_loss_curve{1kHz (0, 0) (0.05, 0.136) (0.08, 0.352) (0.1, 0.552) (0.2, 2.12) (0.3, 4.415) (0.4, 7.307) (0.5, 10.875) (0.6, 15.218) (0.8, 25.858) (1, 39.745) (1.05, 43.805)} core_loss_curve{2kHz (0, 0) (0.02, 0.052) (0.03, 0.119) (0.05, 0.339) (0.08, 0.873) (0.1, 1.367) (0.2, 5.258) (0.3, 11.03) (0.4, 18.396) (0.5, 27.584) (0.6, 39.081) (0.8, 69.513) (1, 112.105) (1.05, 124.9)} core_loss_curve{5kHz (0, 0) (0.01, 0.05) (0.02, 0.199) (0.03, 0.453) (0.05, 1.245) (0.08, 3.111) (0.1, 4.83) (0.2, 18.493) (0.3, 39.455) (0.4, 67.285) (0.5, 102.991) (0.6, 148.889) (0.8, 286.096) (1, 481.155)} core_loss_curve{10kHz (0, 0) (0.005, 0.036) (0.01, 0.146) (0.02, 0.58) (0.03, 1.289) (0.05, 3.524) (0.08, 8.806) (0.1, 13.605) (0.2, 51.496) (0.3, 111.101) (0.4, 193.699) (0.5, 302.656) (0.6, 446.538) (0.8, 876.617)} core_loss_curve{20kHz (0, 0) (0.002, 0.016) (0.005, 0.111) (0.01, 0.455) (0.02, 1.796) (0.0299, 3.993) (0.0499, 10.884) (0.0799, 27.094) (0.0998, 41.639) (0.1997, 156.977) (0.2995, 345.639) (0.3993, 621.946) (0.4991, 989.358) (0.5988, 1457.13)} permeability{BType=normal HUnit=A_per_meter BUnit=tesla curve (0, 0) (1, 0.0007) (2, 0.0017) (5, 0.0065) (10, 0.0185) (15, 0.033) (20, 0.0515) (25, 0.0733) (30, 0.0973) (40, 0.1471) (50, 0.1947) (60, 0.2387) (70, 0.2796) (80, 0.3176) (100, 0.3856) (125, 0.4546) (150, 0.5079) (175, 0.5492) (200, 0.5824) (250, 0.6349) (300, 0.6779) (400, 0.754) (500, 0.8264) (800, 1.035) (1000, 1.1618) (1500, 1.3539) (2000, 1.421) (2500, 1.4604) (3000, 1.4994) (4000, 1.554) (5000, 1.5993) (8000, 1.7006) (10000, 1.7516) (15000, 1.8498) (20000, 1.8991) (30000, 1.9392) (40000, 1.9578) (50000, 1.9723) (55000, 1.9786)} core_loss_type="Electrical Steel" core_loss_kh=404.12017 core_loss_kc=0.056297105 mass_density=7570
  JFE_Steel_50JNE470: core_loss_curve{50Hz (0, 0) (0.5, 0.46) (0.55, 0.53) (0.6, 0.61) (0.65, 0.7) (0.7, 0.79) (0.75, 0.88) (0.8, 0.98) (0.85, 1.09) (0.9, 1.2) (0.95, 1.31) (1, 1.44) (1.05, 1.57) (1.1, 1.7) (1.15, 1.85) (1.2, 2) (1.25, 2.17) (1.3, 2.35) (1.35, 2.54) (1.4, 2.75) (1.45, 2.97) (1.5, 3.21) (1.55, 3.46) (1.6, 3.72) (1.65, 4) (1.7, 4.28)} core_loss_curve{60Hz (0, 0) (0.5, 0.57) (0.55, 0.67) (0.6, 0.78) (0.65, 0.9) (0.7, 1.01) (0.75, 1.14) (0.8, 1.27) (0.85, 1.4) (0.9, 1.55) (0.95, 1.7) (1, 1.85) (1.05, 2.02) (1.1, 2.19) (1.15, 2.38) (1.2, 2.57) (1.25, 2.78) (1.3, 3) (1.35, 3.23) (1.4, 3.47) (1.45, 3.73) (1.5, 4) (1.55, 4.29) (1.6, 4.61) (1.65, 4.95) (1.7, 5.33)} core_loss_curve{100Hz (0, 0) (0.046, 0.01) (0.1, 0.0585) (0.2, 0.237) (0.3, 0.494) (0.4, 0.817) (0.5, 1.19) (0.6, 1.62) (0.7, 2.1) (0.8, 2.64) (0.9, 3.24) (1, 3.91) (1.1, 4.66) (1.2, 5.47) (1.3, 6.35) (1.4, 7.37) (1.5, 8.56)} core_loss_curve{200Hz (0, 0) (0.028, 0.01) (0.1, 0.155) (0.2, 0.604) (0.3, 1.26) (0.4, 2.11) (0.5, 3.12) (0.6, 4.35) (0.7, 5.78) (0.8, 7.42) (0.9, 9.29) (1, 11.4) (1.1, 13.8) (1.2, 16.4) (1.3, 19.3) (1.4, 22.5) (1.5, 26.3)} core_loss_curve{400Hz (0, 0) (0.016, 0.01) (0.1, 0.456) (0.2, 1.74) (0.3, 3.64) (0.4, 6.1) (0.5, 9.12) (0.6, 12.8) (0.7, 17.1) (0.8, 22.2) (0.9, 28.3) (1, 35.4) (1.1, 43.4) (1.2, 52.6) (1.3, 63) (1.4, 75.2)} core_loss_curve{1kHz (0, 0) (0.01, 0.022) (0.1, 2.03) (0.2, 7.12) (0.3, 14.4) (0.4, 24.4) (0.5, 37) (0.6, 53.3) (0.7, 73.5) (0.8, 99.6) (0.81, 100)} core_loss_curve{2kHz (0, 0) (0.01, 0.079) (0.1, 5.98) (0.2, 20.6) (0.3, 41.8) (0.4, 71.3) (0.47, 100)} core_loss_curve{5kHz (0, 0) (0.01, 0.37) (0.05, 7.22) (0.1, 25.1) (0.15, 50.2) (0.2, 83.8) (0.22, 100)} core_loss_curve{10kHz (0, 0) (0.01, 1.05) (0.05, 20.7) (0.1, 67.6) (0.13, 100)} permeability{BType=normal HUnit=A_per_meter BUnit=tesla curve (0, 0) (10, 0.02) (22.2, 0.05) (29.7, 0.101) (35.3, 0.151) (39.6, 0.202) (43, 0.252) (46.2, 0.303) (49.3, 0.353) (52.3, 0.403) (55.4, 0.458) (58.4, 0.509) (61.4, 0.555) (64.8, 0.605) (68.3, 0.655) (72.3, 0.706) (76.5, 0.756) (81.1, 0.807) (85.9, 0.857) (91.5, 0.907) (98.1, 0.958) (106, 1.008) (115, 1.059) (125, 1.109) (138, 1.16) (154, 1.21) (176, 1.26) (205, 1.311) (245, 1.361) (300, 1.412) (382, 1.462) (517, 1.513) (791, 1.564) (1310, 1.615) (2280, 1.666) (3830, 1.719) (5000, 1.755) (5510, 1.77) (7410, 1.817) (9810, 1.864) (10000, 1.867) (13000, 1.914) (17500, 1.972) (26300, 2.033) (51000, 2.114) (80000, 2.161)} conductivity=2777778 core_loss_type="Electrical Steel" core_loss_kh=385.88374 core_loss_kc=0.060953017 core_loss_ke=15.801412 mass_density=7750
  JFE_Steel_35JNE300: core_loss_curve{50Hz (0, 0) (0.5, 0.35) (0.55, 0.4) (0.6, 0.47) (0.65, 0.54) (0.7, 0.62) (0.75, 0.7) (0.8, 0.78) (0.85, 0.86) (0.9, 0.95) (0.95, 1.05) (1, 1.15) (1.05, 1.26) (1.1, 1.37) (1.15, 1.5) (1.2, 1.64) (1.25, 1.78) (1.3, 1.93) (1.35, 2.08) (1.4, 2.25) (1.45, 2.42) (1.5, 2.6) (1.55, 2.79) (1.6, 2.99) (1.65, 3.2) (1.7, 3.43)} core_loss_curve{60Hz (0, 0) (0.5, 0.4) (0.55, 0.51) (0.6, 0.6) (0.65, 0.69) (0.7, 0.78) (0.75, 0.88) (0.8, 0.98) (0.85, 1.09) (0.9, 1.2) (0.95, 1.32) (1, 1.45) (1.05, 1.58) (1.1, 1.72) (1.15, 1.88) (1.2, 2.04) (1.25, 2.22) (1.3, 2.4) (1.35, 2.59) (1.4, 2.79) (1.45, 3.01) (1.5, 3.23) (1.55, 3.47) (1.6, 3.73) (1.65, 4.01) (1.7, 4.3)} core_loss_curve{100Hz (0, 0) (0.053, 0.01) (0.1, 0.0405) (0.2, 0.17) (0.3, 0.362) (0.4, 0.599) (0.5, 0.871) (0.6, 1.18) (0.7, 1.51) (0.8, 1.85) (0.9, 2.24) (1, 2.68) (1.1, 3.17) (1.2, 3.73) (1.3, 4.35) (1.4, 5.07) (1.5, 5.9)} core_loss_curve{200Hz (0, 0) (0.034, 0.01) (0.1, 0.102) (0.2, 0.415) (0.3, 0.886) (0.4, 1.51) (0.5, 2.22) (0.6, 2.99) (0.7, 3.88) (0.8, 4.87) (0.9, 5.97) (1, 7.19) (1.1, 8.56) (1.2, 10.1) (1.3, 11.8) (1.4, 13.8) (1.5, 16)} core_loss_curve{400Hz (0, 0) (0.02, 0.01) (0.1, 0.287) (0.2, 1.12) (0.3, 2.38) (0.4, 4.01) (0.5, 5.97) (0.6, 8.25) (0.7, 10.8) (0.8, 13.6) (0.9, 16.7) (1, 20.3) (1.1, 24.4) (1.2, 29.1) (1.3, 34.3) (1.4, 40.3) (1.5, 47.7)} core_loss_curve{1kHz (0, 0) (0.01, 0.0125) (0.1, 1.24) (0.2, 4.6) (0.3, 9.75) (0.4, 16.1) (0.5, 23.7) (0.6, 33.4) (0.7, 44.8) (0.8, 58.3) (0.9, 74) (1, 93) (1.03, 100)} core_loss_curve{2kHz (0, 0) (0.01, 0.046) (0.1, 3.9) (0.2, 13.7) (0.3, 28.1) (0.4, 46.5) (0.5, 69.7) (0.6, 99)} core_loss_curve{5kHz (0, 0) (0.01, 0.225) (0.05, 4.65) (0.1, 16.3) (0.15, 32.6) (0.2, 54.3) (0.29, 100)} core_loss_curve{10kHz (0, 0) (0.01, 0.7) (0.05, 14.3) (0.1, 47.5) (0.15, 94)} permeability{BType=normal HUnit=A_per_meter BUnit=tesla curve (0, 0) (10, 0.02) (17.2, 0.0499) (23.4, 0.0998) (27.9, 0.1497) (31.7, 0.1995) (34.8, 0.2494) (37.5, 0.2993) (40.1, 0.3492) (42.6, 0.3991) (45, 0.4489) (47.4, 0.4988) (49.8, 0.5488) (52.2, 0.5986) (54.7, 0.6485) (57.5, 0.6983) (60.6, 0.7482) (64.3, 0.7981) (68.3, 0.848) (72.9, 0.8979) (78.2, 0.9477) (84.4, 0.9976) (91.9, 1.0475) (101, 1.0974) (112, 1.1473) (126, 1.1972) (145, 1.2471) (173, 1.297) (214, 1.3469) (282, 1.3969) (408, 1.4469) (681, 1.4971) (1260, 1.5477) (1990, 1.5985) (2810, 1.6494) (3860, 1.7006) (5000, 1.7413) (5310, 1.7516) (7340, 1.8069) (10000, 1.856) (10400, 1.8631) (15000, 1.9188) (22900, 1.9788) (41400, 2.052) (80000, 2.1305)} conductivity=2439024 core_loss_type="Electrical Steel" core_loss_kh=265.17623 core_loss_kc=0.16809354 core_loss_ke=6.3691152 mass_density=7700
  JFE_Steel_35JNE300_2DSF0.960: permeability{BType=normal HUnit=A_per_meter BUnit=tesla curve (0, 0) (10, 0.0192005) (17.2, 0.0479049) (23.4, 0.0958092) (27.9, 0.143713) (31.7, 0.191522) (34.8, 0.239426) (37.5, 0.28733) (40.1, 0.335234) (42.6, 0.383138) (45, 0.430946) (47.4, 0.47885) (49.8, 0.526851) (52.2, 0.574659) (54.7, 0.622563) (57.5, 0.670371) (60.6, 0.718275) (64.3, 0.766179) (68.3, 0.814083) (72.9, 0.861988) (78.2, 0.909796) (84.4, 0.9577) (91.9, 1.0056) (101, 1.05351) (112, 1.10141) (126, 1.14932) (145, 1.19722) (173, 1.24513) (214, 1.29303) (282, 1.34104) (408, 1.38904) (681, 1.43725) (1260, 1.48586) (1990, 1.53466) (2810, 1.58357) (3860, 1.63277) (5000, 1.6719) (5310, 1.6818) (7340, 1.73499) (10000, 1.78226) (10400, 1.7891) (15000, 1.8428) (22900, 1.9008) (41400, 1.972) (80000, 2.0493) (466000, 2.8223)} conductivity=2439020 core_loss_type="Electrical Steel" core_loss_kh=276.225 core_loss_kc=0.175097 core_loss_ke=6.50045 mass_density=7392

design RMxprtDesign1 (RMxprt, Three Phase Induction Motor, model units mm)
machine:
  Machine: FrictionLoss=300W WindLoss=300W ReferenceSpeed=742rpm NumberOfPoles=8 StrayLossFactor=0.015
  Stator: SkewWidth=0 NumberOfSlots=48 LaminationSectors=0 PressBoardThickness=0mm OuterDiameter=808.4mm InnerDiameter=632mm Length=219.2mm StackingFactor=0.96 SteelType=JFE_Steel_35JNE300 SlotType=3
  Rotor: OuterDiameter=630mm InnerDiameter=250mm Length=219.2mm SteelType=JFE_Steel_35JNE300 NumberOfSlots=61 SlotType=4 SkewWidth=1 BottomSlotType=UserDefinedSlot StackingFactor=0.96
  Shaft:
  Stator Slot: Hs0=3mm Hs1=0mm Hs2=48mm Bs0=15mm Bs1=17.5mm Bs2=17.5mm Rs=0mm ParallelTooth ToothWidth=20.3mm
  Stator Winding: WindingType=Whole-Coiled WindingLayers=1 ParallelBranches=1 ConductorsPerSlot=5 CoilPitch=0 EndAdjustment=0mm BaseInnerRadius=0mm TipInnerDiameter=0mm EndClearance=0mm CoilWrap=0mm SlotLiner=0.05mm WedgeThickness=0mm LayerInsulation=0mm BottomInsulation=0mm LimitedFillFactor=0.75 WdgNumberofPriodicMultipler=1 NumberOfStrands=10 WireWrap=0.5mm InterturnInsulation=0mm WireDiameter=2.906mm WireWidth=0mm WireThickness=0mm Gauge=9
  Rotor Slot: Hs0=1.5mm Hs1=1.5mm Hs2=60mm Bs0=1.1mm Bs1=12mm Bs2=8mm Rs=1.55mm Hs01=1mm
  Rotor Winding: BarConductorType=aluminum EndLength=20mm EndRingWidth=25mm EndRingHeight=25mm EndRingConductorType=copper
setups:
  Setup1: TPIM Motor RatedOutputPower=250kW RatedVoltage=400V RatedSpeed=742rpm OperatingTemperature=25cel LoadType=ConstSpeed Frequency=50Hz WindingConnection=0

design Maxwell2DDesign1 (Maxwell 2D, Transient, XY geometry, model units mm)
options: ModelDepth=219.2mm Multiplier=fractions
variables:
  fractions = 1
geometry:
  Band [vacuum] = user_primitive(RMxprt/Band, DiaGap=631mm, DiaYoke=250mm, Length=0mm, SegAngle=0.75deg, Fractions=1, HalfAxial=0, InfoCore=0)
  Shaft [vacuum] = user_primitive(RMxprt/Band, DiaGap=631mm, DiaYoke=250mm, Length=0mm, SegAngle=0.75deg, Fractions=1, HalfAxial=0, InfoCore=100)
  OuterRegion [vacuum] = user_primitive(RMxprt/Band, DiaGap=631mm, DiaYoke=808.4mm, Length=0mm, SegAngle=0.75deg, Fractions=fractions, HalfAxial=0, InfoCore=100)
  Tool = user_primitive(RMxprt/Band, DiaGap=631mm, DiaYoke=808.4mm, Length=0mm, SegAngle=0.75deg, Fractions=fractions, HalfAxial=0, InfoCore=1)
  Stator [JFE_Steel_35JNE300_2DSF0.960] = user_primitive(RMxprt/SlotCore, DiaGap=632mm, DiaYoke=808.4mm, Length=0mm, Skew=0deg, Slots=48, SlotType=3, Hs0=3mm, Hs01=0mm, Hs1=1.9386363mm, Hs2=48mm, Bs0=15mm, Bs1=21.715633mm, Bs2=28.007806mm, Rs=0mm, FilletType=0, HalfSlot=0, SegAngle=15deg, LenRegion=0mm, InfoCore=0)
  Coil_0 [copper] = user_primitive(RMxprt/LapCoil, DiaGap=632mm, DiaYoke=808.4mm, Length=0mm, Skew=0deg, Slots=48, SlotType=3, Hs0=3mm, Hs1=1.9386363mm, Hs2=48mm, Bs0=15mm, Bs1=21.715633mm, Bs2=28.007806mm, Rs=0mm, FilletType=0, Layers=1, CoilPitch=2, EndExt=0mm, SpanExt=0mm, BendAngle=0deg, SegAngle=10deg, LenRegion=0mm, InfoCoil=2)
  Coil_1..Coil_47 [copper] = Coil_0.duplicate_around_axis(axis=Z, angle=7.5deg, total=48)
  Rotor [JFE_Steel_35JNE300_2DSF0.960] = user_primitive(RMxprt/SlotCore, DiaGap=630mm, DiaYoke=250mm, Length=0mm, Skew=0deg, Slots=61, SlotType=4, Hs0=1.5mm, Hs01=1mm, Hs1=1.5mm, Hs2=60mm, Bs0=1.1mm, Bs1=12mm, Bs2=8mm, Rs=1.55mm, FilletType=0, HalfSlot=0, SegAngle=15deg, LenRegion=0mm, InfoCore=0)
  Bar [aluminum_25C] = user_primitive(RMxprt/SquirrelCage, DiaGap=630mm, DiaYoke=250mm, Length=0mm, Skew=0deg, Slots=61, SlotType=4, Hs0=1.5mm, Hs01=1mm, Hs1=1.5mm, Hs2=60mm, Bs0=1.1mm, Bs1=12mm, Bs2=8mm, Rs=1.55mm, FilletType=0, HalfSlot=0, BarEndExt=20mm, RingLength=25mm, RingHeight=25mm, RingDiaGap=0mm, CastRotor=0, SegAngle=15deg, LenRegion=0mm, InfoCoil=0)
  Tool_1 = Tool.copy()
  Bar.subtract(Tool_1)
  Bar_Separate1..Bar_Separate60 [aluminum_25C] = Bar.separate_bodies()
  InnerRegion [vacuum] = user_primitive(RMxprt/SlotCore, DiaGap=630mm, DiaYoke=250mm, Length=0mm, Skew=0deg, Slots=61, SlotType=4, Hs0=1.5mm, Hs01=1mm, Hs1=1.5mm, Hs2=60mm, Bs0=1.1mm, Bs1=12mm, Bs2=8mm, Rs=1.55mm, FilletType=0, HalfSlot=0, SegAngle=15deg, LenRegion=0mm, InfoCore=100)
  Tool_2 = Tool.copy()
  Band.subtract(Tool_2)
  Tool_3 = Tool.copy()
  InnerRegion.subtract(Tool_3)
  Tool_4 = Tool.copy()
  Shaft.subtract(Tool_4)
  Tool_5 = Tool.copy()
  Stator.subtract(Tool_5)
  Tool_6 = Tool.copy()
  Coil_0.subtract(Tool_6)
  Tool_7 = Tool.copy()
  Coil_1.subtract(Tool_7)
  Tool_8 = Tool.copy()
  Coil_2.subtract(Tool_8)
  Tool_9 = Tool.copy()
  Coil_3.subtract(Tool_9)
  Tool_10 = Tool.copy()
  Coil_4.subtract(Tool_10)
  Tool_11 = Tool.copy()
  Coil_5.subtract(Tool_11)
  Tool_12 = Tool.copy()
  Coil_6.subtract(Tool_12)
  Tool_13 = Tool.copy()
  Coil_7.subtract(Tool_13)
  Tool_14 = Tool.copy()
  Coil_8.subtract(Tool_14)
  Tool_15 = Tool.copy()
  Coil_9.subtract(Tool_15)
  Tool_16 = Tool.copy()
  Coil_10.subtract(Tool_16)
  Tool_17 = Tool.copy()
  Coil_11.subtract(Tool_17)
  Tool_18 = Tool.copy()
  Coil_12.subtract(Tool_18)
  Tool_19 = Tool.copy()
  Coil_13.subtract(Tool_19)
  Tool_20 = Tool.copy()
  Coil_14.subtract(Tool_20)
  Tool_21 = Tool.copy()
  Coil_15.subtract(Tool_21)
  Tool_22 = Tool.copy()
  Coil_16.subtract(Tool_22)
  Tool_23 = Tool.copy()
  Coil_17.subtract(Tool_23)
  Tool_24 = Tool.copy()
  Coil_18.subtract(Tool_24)
  Tool_25 = Tool.copy()
  Coil_19.subtract(Tool_25)
  Tool_26 = Tool.copy()
  Coil_20.subtract(Tool_26)
  Tool_27 = Tool.copy()
  Coil_21.subtract(Tool_27)
  Tool_28 = Tool.copy()
  Coil_22.subtract(Tool_28)
  Tool_29 = Tool.copy()
  Coil_23.subtract(Tool_29)
  Tool_30 = Tool.copy()
  Coil_24.subtract(Tool_30)
  Tool_31 = Tool.copy()
  Coil_25.subtract(Tool_31)
  Tool_32 = Tool.copy()
  Coil_26.subtract(Tool_32)
  Tool_33 = Tool.copy()
  Coil_27.subtract(Tool_33)
  Tool_34 = Tool.copy()
  Coil_28.subtract(Tool_34)
  Tool_35 = Tool.copy()
  Coil_29.subtract(Tool_35)
  Tool_36 = Tool.copy()
  Coil_30.subtract(Tool_36)
  Tool_37 = Tool.copy()
  Coil_31.subtract(Tool_37)
  Tool_38 = Tool.copy()
  Coil_32.subtract(Tool_38)
  Tool_39 = Tool.copy()
  Coil_33.subtract(Tool_39)
  Tool_40 = Tool.copy()
  Coil_34.subtract(Tool_40)
  Tool_41 = Tool.copy()
  Coil_35.subtract(Tool_41)
  Tool_42 = Tool.copy()
  Coil_36.subtract(Tool_42)
  Tool_43 = Tool.copy()
  Coil_37.subtract(Tool_43)
  Tool_44 = Tool.copy()
  Coil_38.subtract(Tool_44)
  Tool_45 = Tool.copy()
  Coil_39.subtract(Tool_45)
  Tool_46 = Tool.copy()
  Coil_40.subtract(Tool_46)
  Tool_47 = Tool.copy()
  Coil_41.subtract(Tool_47)
  Tool_48 = Tool.copy()
  Coil_42.subtract(Tool_48)
  Tool_49 = Tool.copy()
  Coil_43.subtract(Tool_49)
  Tool_50 = Tool.copy()
  Coil_44.subtract(Tool_50)
  Tool_51 = Tool.copy()
  Coil_45.subtract(Tool_51)
  Tool_52 = Tool.copy()
  Coil_46.subtract(Tool_52)
  Tool_53 = Tool.copy()
  Coil_47.subtract(Tool_53)
  Rotor.subtract(Tool)
motion:
  MotionSetup1: Band Move_Type=Rotate Coordinate_System=Global Axis=Z Is_Positive=true InitPos=0deg Angular_Velocity=742rpm Objects=Band
  Moving1: Moving Objects=[Shaft, Rotor, Bar, Bar_Separate1..Bar_Separate60, InnerRegion]
boundaries and excitations:
  VectorPotential1: Vector Potential Edges=OuterRegion.edge(at (0, 404.2, 0)) Value=0
  PhARe_0: Coil Objects=Coil_43 Conductor_number=5 Winding=PhaseA PolarityType=Negative
  PhA_0: Coil Objects=Coil_0 Conductor_number=5 Winding=PhaseA PolarityType=Positive
  PhA_1: Coil Objects=Coil_1 Conductor_number=5 Winding=PhaseA PolarityType=Positive
  PhARe_1: Coil Objects=Coil_6 Conductor_number=5 Winding=PhaseA PolarityType=Negative
  PhBRe_2: Coil Objects=Coil_47 Conductor_number=5 Winding=PhaseB PolarityType=Negative
  PhB_2: Coil Objects=Coil_4 Conductor_number=5 Winding=PhaseB PolarityType=Positive
  PhB_3: Coil Objects=Coil_5 Conductor_number=5 Winding=PhaseB PolarityType=Positive
  PhBRe_3: Coil Objects=Coil_10 Conductor_number=5 Winding=PhaseB PolarityType=Negative
  PhCRe_4: Coil Objects=Coil_3 Conductor_number=5 Winding=PhaseC PolarityType=Negative
  PhC_4: Coil Objects=Coil_8 Conductor_number=5 Winding=PhaseC PolarityType=Positive
  PhC_5: Coil Objects=Coil_9 Conductor_number=5 Winding=PhaseC PolarityType=Positive
  PhCRe_5: Coil Objects=Coil_14 Conductor_number=5 Winding=PhaseC PolarityType=Negative
  PhARe_6: Coil Objects=Coil_7 Conductor_number=5 Winding=PhaseA PolarityType=Negative
  PhA_6: Coil Objects=Coil_12 Conductor_number=5 Winding=PhaseA PolarityType=Positive
  PhA_7: Coil Objects=Coil_13 Conductor_number=5 Winding=PhaseA PolarityType=Positive
  PhARe_7: Coil Objects=Coil_18 Conductor_number=5 Winding=PhaseA PolarityType=Negative
  PhBRe_8: Coil Objects=Coil_11 Conductor_number=5 Winding=PhaseB PolarityType=Negative
  PhB_8: Coil Objects=Coil_16 Conductor_number=5 Winding=PhaseB PolarityType=Positive
  PhB_9: Coil Objects=Coil_17 Conductor_number=5 Winding=PhaseB PolarityType=Positive
  PhBRe_9: Coil Objects=Coil_22 Conductor_number=5 Winding=PhaseB PolarityType=Negative
  PhCRe_10: Coil Objects=Coil_15 Conductor_number=5 Winding=PhaseC PolarityType=Negative
  PhC_10: Coil Objects=Coil_20 Conductor_number=5 Winding=PhaseC PolarityType=Positive
  PhC_11: Coil Objects=Coil_21 Conductor_number=5 Winding=PhaseC PolarityType=Positive
  PhCRe_11: Coil Objects=Coil_26 Conductor_number=5 Winding=PhaseC PolarityType=Negative
  PhARe_12: Coil Objects=Coil_19 Conductor_number=5 Winding=PhaseA PolarityType=Negative
  PhA_12: Coil Objects=Coil_24 Conductor_number=5 Winding=PhaseA PolarityType=Positive
  PhA_13: Coil Objects=Coil_25 Conductor_number=5 Winding=PhaseA PolarityType=Positive
  PhARe_13: Coil Objects=Coil_30 Conductor_number=5 Winding=PhaseA PolarityType=Negative
  PhBRe_14: Coil Objects=Coil_23 Conductor_number=5 Winding=PhaseB PolarityType=Negative
  PhB_14: Coil Objects=Coil_28 Conductor_number=5 Winding=PhaseB PolarityType=Positive
  PhB_15: Coil Objects=Coil_29 Conductor_number=5 Winding=PhaseB PolarityType=Positive
  PhBRe_15: Coil Objects=Coil_34 Conductor_number=5 Winding=PhaseB PolarityType=Negative
  PhCRe_16: Coil Objects=Coil_27 Conductor_number=5 Winding=PhaseC PolarityType=Negative
  PhC_16: Coil Objects=Coil_32 Conductor_number=5 Winding=PhaseC PolarityType=Positive
  PhC_17: Coil Objects=Coil_33 Conductor_number=5 Winding=PhaseC PolarityType=Positive
  PhCRe_17: Coil Objects=Coil_38 Conductor_number=5 Winding=PhaseC PolarityType=Negative
  PhARe_18: Coil Objects=Coil_31 Conductor_number=5 Winding=PhaseA PolarityType=Negative
  PhA_18: Coil Objects=Coil_36 Conductor_number=5 Winding=PhaseA PolarityType=Positive
  PhA_19: Coil Objects=Coil_37 Conductor_number=5 Winding=PhaseA PolarityType=Positive
  PhARe_19: Coil Objects=Coil_42 Conductor_number=5 Winding=PhaseA PolarityType=Negative
  PhBRe_20: Coil Objects=Coil_35 Conductor_number=5 Winding=PhaseB PolarityType=Negative
  PhB_20: Coil Objects=Coil_40 Conductor_number=5 Winding=PhaseB PolarityType=Positive
  PhB_21: Coil Objects=Coil_41 Conductor_number=5 Winding=PhaseB PolarityType=Positive
  PhBRe_21: Coil Objects=Coil_46 Conductor_number=5 Winding=PhaseB PolarityType=Negative
  PhCRe_22: Coil Objects=Coil_39 Conductor_number=5 Winding=PhaseC PolarityType=Negative
  PhC_22: Coil Objects=Coil_44 Conductor_number=5 Winding=PhaseC PolarityType=Positive
  PhC_23: Coil Objects=Coil_45 Conductor_number=5 Winding=PhaseC PolarityType=Positive
  PhCRe_23: Coil Objects=Coil_2 Conductor_number=5 Winding=PhaseC PolarityType=Negative
  EndConnection1: End Connection Objects=[Bar, Bar_Separate1..Bar_Separate60] ResistanceValue=8.37475e-007ohm InductanceValue=2.55599e-008H
  PhaseA: Winding Group Type=Voltage IsSolid=false Current=0A Resistance=0.011747ohm Inductance=8.85682e-005H Voltage="326.599 * sin(2*pi*50*time)" ParallelBranchesNum=1
  PhaseB: Winding Group Type=Voltage IsSolid=false Current=0A Resistance=0.011747ohm Inductance=8.85682e-005H Voltage="326.599 * sin(2*pi*50*time-2*pi/3)" ParallelBranchesNum=1
  PhaseC: Winding Group Type=Voltage IsSolid=false Current=0A Resistance=0.011747ohm Inductance=8.85682e-005H Voltage="326.599 * sin(2*pi*50*time-4*pi/3)" ParallelBranchesNum=1
  Y connection: PhaseA, PhaseB, PhaseC
parameters:
  CoggingTorque: Torque Coordinate_System=Global Is_Positive=true Objects=Rotor
mesh:
  Length_Coil: LengthBased RefineInside Objects=[Coil_0..Coil_47] MaxLength=12.4309mm
  Length_Bar: LengthBased RefineInside Objects=[Bar, Bar_Separate1..Bar_Separate60] MaxLength=4mm
  SurfApprox_Bar: SurfApproxBased Objects=[Bar, Bar_Separate1..Bar_Separate60] CurvedSurfaceApproxChoice=ManualSettings SurfDev=0.315mm NormalDev=15deg
  SurfApprox_Main: SurfApproxBased Objects=[Stator, Rotor, Band, OuterRegion, InnerRegion, Shaft] CurvedSurfaceApproxChoice=ManualSettings SurfDev=0.4042mm NormalDev=15deg
  Length_Main: LengthBased RefineInside Objects=[Stator, Rotor, Band, OuterRegion, InnerRegion, Shaft] MaxLength=17.84mm
  initial mesh: MeshMethod=AnsoftTAU
setups:
  Setup1: Transient NonlinearSolverResidual=0.0001 StopTime=600ms TimeStep=2ms FastReachSteadyState FrequencyOfAddedVoltageSource=50Hz SweepSetupType=LinearStep StartValue=590000000ns StopValue=600ms StepSize=2ms InitialTimeStep=0.002s MinTimeStep=0.001s MaxTimeStep=0.003s TimeStepErrTolerance=0.0001
field plots:
  Mag_B1, B_Vector1: B over Band, Shaft, OuterRegion, Stator, Coil_0..Coil_47, Rotor, Bar, Bar_Separate1..Bar_Separate60, InnerRegion on Setup1 : Transient at Time=0.594s
  Flux_Lines1: A over Band, Shaft, OuterRegion, Stator, Coil_0..Coil_47, Rotor, Bar, Bar_Separate1..Bar_Separate60, InnerRegion on Setup1 : Transient at Time=0.594s
reports:
  Torque: Moving1.Torque vs Time on Setup1 : Transient
  Currents: Current(PhaseA), Current(PhaseB), Current(PhaseC) vs Time on Setup1 : Transient
  Induced Voltages: InducedVoltage(PhaseA), InducedVoltage(PhaseB), InducedVoltage(PhaseC) vs Time on Setup1 : Transient
  Flux Linkages: FluxLinkage(PhaseA), FluxLinkage(PhaseB), FluxLinkage(PhaseC) vs Time on Setup1 : Transient
  Voltages: InputVoltage(PhaseA), InputVoltage(PhaseB), InputVoltage(PhaseC) vs Time on Setup1 : Transient
  Powers: InputVoltage(PhaseA)*Current(PhaseA) + InputVoltage(PhaseB)*Current(PhaseB) + InputVoltage(PhaseC)*Current(PhaseC), Moving1.Speed*Moving1.Torque vs Time on Setup1 : Transient
  XY Plot 1: CoggingTorque.Torque vs Time on Setup1 : Transient
